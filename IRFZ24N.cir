.SUBCKT IRFZ24N 1 2 3
M1 9 7 8 8 MM L=100u W=100u
.MODEL MM NMOS LEVEL=1 IS=1e-32
+VTO=3.6319 LAMBDA=0 KP=8.99346
+CGSO=3.09714e-06 CGDO=1.6185e-07
RS 8 3 0.0409355
D1 3 1 MD
.MODEL MD D IS=1.43387e-10 RS=0.0112766 N=1.28803 BV=55
+IBV=0.00025 EG=1.2 XTI=2.96465 TT=0
+CJO=2.96476e-10 VJ=0.50803 M=0.3 FC=0.5
RDS 3 1 2.2e+06
RD 9 1 0.0001
RG 2 7 2.4575
D2 4 5 MD1
.MODEL MD1 D IS=1e-32 N=50
+CJO=4.37817e-10 VJ=0.5 M=0.578699 FC=1e-08
D3 0 5 MD2
.MODEL MD2 D IS=1e-10 N=0.4 RS=3e-06
RL 5 10 1
FI2 7 9 VFI2 -1
VFI2 4 0 0
EV16 10 0 9 7 1
CAP 11 10 6.81971e-10
FI1 7 9 VFI1 -1
VFI1 11 6 0
RCAP 6 10 1
D4 0 6 MD3
.MODEL MD3 D IS=1e-10 N=0.4
.ENDS IRFZ24N
