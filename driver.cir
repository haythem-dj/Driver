H-Bridge Driver
.tran 1u 0.02

V1 in gnd PULSE(0 24 0 1u 1u 1 1)
Vg l gnd PULSE(5 -5 0.01 1u 1u 1 1)

Xnmos nd ng ns irfz24n_IR
Rln in nd 1k
Rgn l ng 100
Vins ns gnd dc 0

Xpmos pd pg ps irf9z34n_IR
Rlp ps gnd 1k
Rgp l pg 100
Vips in pd dc 0

.control
run
set filetype=ascii
write driver.data in l ng pg nd pd i(Vins) i(Vips)
.endc

**************************************
.SUBCKT irfz24n_IR 1 2 3
M1 9 7 8 8 MM L=100u W=100u
.MODEL MM NMOS LEVEL=1 IS=1e-32
+VTO=3.6319 LAMBDA=0 KP=8.99346
+CGSO=3.09714e-06 CGDO=1.6185e-07
RS 8 3 0.0409355
D1 3 1 MD
.MODEL MD D IS=1.43387e-10 RS=0.0112766 N=1.28803 BV=55
+IBV=0.00025 EG=1.2 XTI=2.96465 TT=0
+CJO=2.96476e-10 VJ=0.50803 M=0.3 FC=0.5
RDS 3 1 2.2e+06
RD 9 1 0.0001
RG 2 7 2.4575
D2 4 5 MD1
.MODEL MD1 D IS=1e-32 N=50
+CJO=4.37817e-10 VJ=0.5 M=0.578699 FC=1e-08
D3 0 5 MD2
.MODEL MD2 D IS=1e-10 N=0.4 RS=3e-06
RL 5 10 1
FI2 7 9 VFI2 -1
VFI2 4 0 0
EV16 10 0 9 7 1
CAP 11 10 6.81971e-10
FI1 7 9 VFI1 -1
VFI1 11 6 0
RCAP 6 10 1
D4 0 6 MD3
.MODEL MD3 D IS=1e-10 N=0.4
.ENDS

**************************************
.SUBCKT irf9z34n_IR 1 2 3
M1 9 7 8 8 MM L=100u W=100u
.MODEL MM PMOS LEVEL=1 IS=1e-32
+VTO=-3.18176 LAMBDA=0 KP=2.52466
+CGSO=4.9266e-06 CGDO=1e-11
RS 8 3 0.0001
D1 1 3 MD
.MODEL MD D IS=2.51148e-12 RS=0.0124373 N=1.05244 BV=55
+IBV=0.00025 EG=1 XTI=2.91741 TT=0.0001
+CJO=4.87958e-10 VJ=5 M=0.731488 FC=0.5
RDS 3 1 1e+06
RD 9 1 0.028942
RG 2 7 6
D2 5 4 MD1
.MODEL MD1 D IS=1e-32 N=50
+CJO=8.50824e-10 VJ=0.5 M=0.456256 FC=1e-08
D3 5 0 MD2
.MODEL MD2 D IS=1e-10 N=0.4 RS=3e-06
RL 5 10 1
FI2 7 9 VFI2 -1
VFI2 4 0 0
EV16 10 0 9 7 1
CAP 11 10 8.50824e-10
FI1 7 9 VFI1 -1
VFI1 11 6 0
RCAP 6 10 1
D4 6 0 MD3
.MODEL MD3 D IS=1e-10 N=0.4
.ENDS irf9z34n_IR
**************************************

.end
