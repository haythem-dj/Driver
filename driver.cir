H-Bridge Driver
.tran 1u 0.02

.include switchs.cir

V1 vcc gnd PULSE(0 24 0 1u 1u 1 1)
Vctrl1 ctrl1 gnd PULSE(0 5 0 1u 1u 0.005 0.01)
Vctrl2 ctrl2 gnd PULSE(0 5 0.005 1u 1u 0.005 0.01)

Rload o1 o2 1k

XS1 vcc gnd ctrl1 o1 HS
XS2 gnd ctrl1 o2 LS
XS3 gnd ctrl2 o1 LS
XS4 vcc gnd ctrl2 o2 HS

.control
run
set filetype=ascii
write driver.data vcc ctrl1 ctrl2 v(o1,o2)
.endc

.end
