.SUBCKT IRF9Z34N 1 2 3
M1 9 7 8 8 MM L=100u W=100u
.MODEL MM PMOS LEVEL=1 IS=1e-32
+VTO=-3.18176 LAMBDA=0 KP=2.52466
+CGSO=4.9266e-06 CGDO=1e-11
RS 8 3 0.0001
D1 1 3 MD
.MODEL MD D IS=2.51148e-12 RS=0.0124373 N=1.05244 BV=55
+IBV=0.00025 EG=1 XTI=2.91741 TT=0.0001
+CJO=4.87958e-10 VJ=5 M=0.731488 FC=0.5
RDS 3 1 1e+06
RD 9 1 0.028942
RG 2 7 6
D2 5 4 MD1
.MODEL MD1 D IS=1e-32 N=50
+CJO=8.50824e-10 VJ=0.5 M=0.456256 FC=1e-08
D3 5 0 MD2
.MODEL MD2 D IS=1e-10 N=0.4 RS=3e-06
RL 5 10 1
FI2 7 9 VFI2 -1
VFI2 4 0 0
EV16 10 0 9 7 1
CAP 11 10 8.50824e-10
FI1 7 9 VFI1 -1
VFI1 11 6 0
RCAP 6 10 1
D4 6 0 MD3
.MODEL MD3 D IS=1e-10 N=0.4
.ENDS IRF9Z34N
